q4 finite-region canonical regeneration
* Behavioral references/buffers are ideal; port energy is not full supply energy.
.model WRITE SW(Ron=1000 Roff=1e18 Vt=0.5 Vh=0.05)
.model SAMPLE SW(Ron=1 Roff=1e18 Vt=0.5 Vh=0.05)
.model LATCH SW(Ron=10000 Roff=1e18 Vt=0.5 Vh=0.05)
.options plotwinsize=0 numdgt=15 reltol=1e-8 abstol=1e-18 vntol=1e-11
Vcm cm 0 .6
Vpacket packet 0 1.2
Vin input 0 0.0325
Vrs rs 0 PWL(0n 0 1n 0 1.01n 1 1.19n 1 1.2n 0)
Vrr rr 0 PWL(0n 0 1.5n 0 1.51n 1 1.99n 1 2n 0)
Vrw rw 0 PWL(0n 0 2.2n 0 2.21n 1 4.19n 1 4.2n 0)
Brcode rcode 0 V=-3+if(((V(input))/0.025+(0))>-2.5,1,0)+if(((V(input))/0.025+(0))>-1.5,1,0)+if(((V(input))/0.025+(0))>-0.5,1,0)+if(((V(input))/0.025+(0))>0.5,1,0)+if(((V(input))/0.025+(0))>1.5,1,0)+if(((V(input))/0.025+(0))>2.5,1,0)
Brbad rbad 0 V=if(((V(input))/0.025+(0))<-3.5+(0),1,if(((V(input))/0.025+(0))>=3.5+(0),1,if((0)>.5,1,0)))
Srcode rcode rh rs 0 LATCH
Crh rh 0 1f IC=0
Rrh rh 0 1e18
Srbad rbad rbh rs 0 LATCH
Crbh rbh 0 1f IC=0
Rrbh rbh 0 1e18
Cro0 ro0 0 5e-14 IC=0.6
Rro0 ro0 cm 2e+16
Srreset0 ro0 cm rr 0 WRITE
Brpacket01 packet ro0 I=3.1407035175879e-07*(if(abs(V(rh))>0.5,if(V(rh)>0,1,-1),0)*V(rw)*if(V(rbh)<.5,1,0))
Brpacket02 packet ro0 I=3.1407035175879e-07*(if(abs(V(rh))>1.5,if(V(rh)>0,1,-1),0)*V(rw)*if(V(rbh)<.5,1,0))
Brpacket03 packet ro0 I=3.1407035175879e-07*(if(abs(V(rh))>2.5,if(V(rh)>0,1,-1),0)*V(rw)*if(V(rbh)<.5,1,0))
Cro1 ro1 0 5e-14 IC=0.6
Rro1 ro1 cm 2e+16
Srreset1 ro1 cm rr 0 WRITE
Brpacket11 packet ro1 I=-3.1407035175879e-07*(if(abs(V(rh))>0.5,if(V(rh)>0,1,-1),0)*V(rw)*if(V(rbh)<.5,1,0))
Brpacket12 packet ro1 I=-3.1407035175879e-07*(if(abs(V(rh))>1.5,if(V(rh)>0,1,-1),0)*V(rw)*if(V(rbh)<.5,1,0))
Brpacket13 packet ro1 I=-3.1407035175879e-07*(if(abs(V(rh))>2.5,if(V(rh)>0,1,-1),0)*V(rw)*if(V(rbh)<.5,1,0))
Brbuffer rout 0 V=V(ro0,ro1)
.save i(vcm) i(vpacket) v(cm) v(rbh) v(rh) v(ro0) v(ro1) v(rout)
.tran 0 6.2n 0 0.04n UIC
.end
