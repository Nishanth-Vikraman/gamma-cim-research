Gamma-CIM runtime smoke test
V1 a 0 PULSE(0 1 1n 10p 10p 1n 4n)
R1 a b 1k
C1 b 0 1p
.save V(a) V(b)
.options plotwinsize=0 numdgt=15
.tran 0 10n 0 20p
.end
